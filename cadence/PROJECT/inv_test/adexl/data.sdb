ADE simulation setup
Run mode: Single Run, Sweeps and Corners
Tests:
  PROJECT:inv_test:1: PROJECT/inv_test/schematic, simulator spectre
