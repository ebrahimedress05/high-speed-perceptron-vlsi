ADE simulation setup
Run mode: Single Run, Sweeps and Corners
Tests:
  PROJECT:MuX_test:1: PROJECT/MuX_test/schematic, simulator spectre
Global variables:
  W = 120n
  L = 60n
