ADE simulation setup
Run mode: Single Run, Sweeps and Corners
Tests:
  PROJECT:Xor:1: PROJECT/Xor/schematic, simulator spectre
