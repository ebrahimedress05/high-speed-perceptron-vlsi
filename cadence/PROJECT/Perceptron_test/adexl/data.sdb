ADE simulation setup
Run mode: Single Run, Sweeps and Corners
Tests:
  PROJECT:Perceptron_test:1: PROJECT/Perceptron_test/schematic, simulator spectre
    Outputs: adder; u_multi; d_multi; Total
Global variables:
  W = 120n
  L = 60n
  V = 1.2
