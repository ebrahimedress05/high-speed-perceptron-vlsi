ADE simulation setup
Run mode: Single Run, Sweeps and Corners
Tests:
  PROJECT:CLA_test:1: PROJECT/CLA_test/schematic, simulator spectre
Global variables:
  W = 120n (off)
  L = 60n (off)
