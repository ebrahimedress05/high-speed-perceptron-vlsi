ADE simulation setup
Run mode: Single Run, Sweeps and Corners
Tests:
  PROJECT:Multiplier_test:1: PROJECT/Multiplier_test/schematic, simulator spectre
