ADE simulation setup
Run mode: Single Run, Sweeps and Corners
Tests:
  PROJECT:Perceptron_delay:1: PROJECT/Perceptron_delay/schematic, simulator spectre
Global variables:
  W = 120n (off)
  L = 60n (off)
  V = 1.2
